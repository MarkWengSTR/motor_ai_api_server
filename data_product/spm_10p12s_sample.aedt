# Ansys Electronics Desktop project, version 2018.2
materials:
  vacuum: permittivity=1
  N44SH_20deg_mag: permeability=1.0665022 conductivity=625000 magnetic_coercivity{Magnitude=-970kA_per_meter DirComp1=1 DirComp2=0 DirComp3=0}
  35CS250_steel: core_loss_curve{50Hz (0, 0) (0.082126, 0.010785) (0.19661, 0.060342) (0.37832, 0.1907) (0.56633, 0.3711) (0.72816, 0.55896) (0.85457, 0.72653) (0.95124, 0.86882) (1.023, 0.98313) (1.0837, 1.088) (1.1281, 1.1682) (1.1699, 1.2485) (1.201, 1.3116) (1.2274, 1.3677) (1.2484, 1.4145) (1.2683, 1.4597) (1.2849, 1.4994) (1.299, 1.5338) (1.3104, 1.563) (1.3227, 1.5944) (1.3414, 1.6454) (1.3579, 1.692) (1.3707, 1.7289) (1.3826, 1.765) (1.3925, 1.7957) (1.4033, 1.8297) (1.4128, 1.8608) (1.4208, 1.8884) (1.4283, 1.9135) (1.4353, 1.9381) (1.4413, 1.9586) (1.4474, 1.9793) (1.4525, 1.9974) (1.4622, 2.0317) (1.4706, 2.0625) (1.4779, 2.0888) (1.4852, 2.1159) (1.492, 2.1413) (1.4978, 2.1599) (1.5033, 2.1834) (1.5083, 2.2009) (1.5137, 2.2206) (1.5186, 2.2384) (1.5575, 2.38) (1.5877, 2.4856) (1.6125, 2.5645) (1.6346, 2.6324) (1.6546, 2.692) (1.6724, 2.7539) (1.6896, 2.8039) (1.7049, 2.8469) (1.7335, 2.9301) (1.7591, 3.0205) (1.782, 3.0827) (1.8027, 3.161) (1.8217, 3.2159) (1.8623, 3.325) (1.8952, 3.4333) (1.9208, 3.5014) (1.941, 3.5283)} core_loss_curve{400Hz (0, 0) (0.050769, 0.068195) (0.097532, 0.25864) (0.15985, 0.67753) (0.24064, 1.4415) (0.33668, 2.6223) (0.44345, 4.2379) (0.55002, 6.1677) (0.6606, 8.5108) (0.75539, 10.812) (0.84532, 13.276) (0.92469, 15.701) (0.99826, 18.18) (1.0757, 21.072) (1.1412, 23.761) (1.2015, 26.488) (1.242, 28.455) (1.2656, 29.662) (1.2835, 30.602) (1.3001, 31.501) (1.321, 32.666) (1.3413, 33.811) (1.356, 34.778) (1.368, 35.496) (1.3784, 36.174) (1.3894, 36.849) (1.3995, 37.53) (1.4086, 38.161) (1.4156, 38.681) (1.4219, 39.123) (1.4288, 39.629) (1.4349, 40.081) (1.4398, 40.454) (1.45, 41.33) (1.4576, 41.926) (1.4667, 42.655) (1.4738, 43.218) (1.4802, 43.789) (1.4869, 44.348) (1.4913, 44.734) (1.4966, 45.213) (1.5023, 45.675) (1.506, 45.977) (1.5144, 46.809) (1.5238, 47.672) (1.5309, 48.366)} core_loss_curve{1000Hz (0, 0) (0.044836, 0.21917) (0.07659, 0.63568) (0.11369, 1.3634) (0.15667, 2.5073) (0.20449, 4.117) (0.2558, 6.2011) (0.31259, 8.9218) (0.36853, 11.959) (0.43248, 15.874) (0.49395, 20.146) (0.55105, 24.581) (0.60421, 29.169) (0.65394, 33.78) (0.70065, 38.568) (0.74416, 43.375) (0.78702, 48.464) (0.82778, 53.632) (0.86668, 58.929) (0.90453, 64.446) (0.97607, 75.859) (1.041, 87.334) (1.1025, 99.62) (1.1585, 111.81) (1.2123, 124.55) (1.2752, 141) (1.331, 156.86) (1.3897, 175.18)} permeability{BType=normal HUnit=A_per_meter BUnit=tesla curve (0, 0) (20.54, 0.065) (41.15, 0.238) (60.94, 0.541) (80.68, 0.755) (100.17, 0.906) (125.56, 1.04) (150.6, 1.13) (175.18, 1.194) (200.47, 1.239) (225.57, 1.274) (250.45, 1.301) (275.26, 1.322) (300.36, 1.34) (350.42, 1.367) (400.16, 1.388) (452.15, 1.405) (506.02, 1.419) (553.74, 1.43) (600.74, 1.439) (653.35, 1.448) (704.25, 1.456) (750.62, 1.463) (802.89, 1.469) (847.4, 1.474) (902.52, 1.48) (958.28, 1.486) (1005.9, 1.491) (1502.3, 1.531) (2002.3, 1.561) (2501.4, 1.586) (3005, 1.608) (3505.1, 1.628) (4004.3, 1.647) (4502.8, 1.663) (5003.4, 1.678) (6009.6, 1.709) (7006.8, 1.734) (8010.2, 1.758) (9004.5, 1.778) (10005, 1.797) (28000, 1.85) (150000, 2.05)} core_loss_type="Electrical Steel" core_loss_kh=182.19798 core_loss_kc=0.46485853 mass_density=7600
  copper: permeability=0.999991 conductivity=58000000

design Maxwell2DDesign1 (Maxwell 2D, Transient, XY geometry, model units mm)
options: ModelDepth=96mm Multiplier=1
variables:
  Dsi = 57mm
  Dso = 105.2mm
  slot = 12
  Hs0 = 1mm
  Hs1 = 1mm
  Bs0 = 4.5mm
  Rs = 0.5mm
  Wt = 9.2mm
  Wy = 6.4mm
  Hs2 = Dso/2-Wy-Hs1-Hs0-Dsi/2
  Bs1 = ((Dsi + (Hs0 + Hs1)*2) *pi -12*Wt)/12
  Bs2 = ((Dsi + (Hs0 + Hs1 + Hs2)*2) *pi -12*Wt)/12
  slot_area = ((Bs1+Bs2)/1mm)/2*(Hs2/1mm)+((Bs0+Bs1)/1mm)/2*(Hs1/1mm)+(Bs2/1mm)*(Rs/1mm)
  airgap = 0.5mm
  Dro = Dsi - airgap*2
  Dri = Dro * 0.4
  pole = 10
  rotor_type = 1
  mag_emb = 0.8mm
  mag_thick = 3mm
  mag_width = 0mm
  rotor_bridge = 0mm
  rotor_rib = 0mm
  ini_angle = 45.5deg
  speed_rpm = 1769rpm
  length = 96mm
  multiplier = 1
  rota_band_D = (Dsi + Dro) / 2
  outer_band_D = (Dso)*1.1
  shaft = Dri
  N = 2
  Im = 297A
  f_ele = speed_rpm/60*(pole/2)/1rpm
  lead_ang = 0
  I_ph_A = Im*sqrt(2)*sin((360*f_ele*Time+lead_ang)*pi/180)
  I_ph_B = Im*sqrt(2)*sin((360*f_ele*Time+lead_ang-120)*pi/180)
  I_ph_C = Im*sqrt(2)*sin((360*f_ele*Time+lead_ang+120)*pi/180)
geometry:
  stator [35CS250_steel] = user_primitive(RMxprt/SlotCore.dll, DiaGap=57mm, DiaYoke=105.2mm, Length=0mm, Skew=0deg, Slots=12, SlotType=3, Hs0=1mm, Hs01=0mm, Hs1=1mm, Hs2=Dso/2-Wy-Hs1-Hs0-Dsi/2, Bs0=4.5mm, Bs1=((Dsi + (Hs0 + Hs1)*2) *pi -12*Wt)/12, Bs2=((Dsi + (Hs0 + Hs1 + Hs2)*2) *pi -12*Wt)/12, Rs=0.5mm, FilletType=2, HalfSlot=0, SegAngle=15deg, LenRegion=200mm, InfoCore=0)
  rotor [35CS250_steel] = user_primitive(RMxprt/PMCore.dll, DiaGap=Dsi - airgap*2, DiaYoke=Dro * 0.4, Length=0mm, Poles=10, PoleType=1, Embrace=0.8, ThickMag=3mm, WidthMag=0mm, Offset=0mm, Bridge=0mm, Rib=0mm, LenRegion=200mm, InfoCore=0)
  coordinate_system RelativeCS0 = origin=(0mm, 0mm, 0mm) Euler Angle ZXZ phi=18deg theta=0deg psi=0deg
  magnet [N44SH_20deg_mag, oriented by RelativeCS0] = user_primitive(RMxprt/PMCore.dll, DiaGap=Dsi - airgap*2, DiaYoke=Dro * 0.4, Length=0mm, Poles=10, PoleType=1, Embrace=0.8, ThickMag=3mm, WidthMag=0mm, Offset=0mm, Bridge=0mm, Rib=0mm, LenRegion=200mm, InfoCore=2)
  magnet_1 [N44SH_20deg_mag, oriented by RelativeCS1], magnet_2 [N44SH_20deg_mag, oriented by RelativeCS2], magnet_3 [N44SH_20deg_mag, oriented by RelativeCS3], magnet_4 [N44SH_20deg_mag, oriented by RelativeCS4], magnet_5 [N44SH_20deg_mag, oriented by RelativeCS5], magnet_6 [N44SH_20deg_mag, oriented by RelativeCS6], magnet_7 [N44SH_20deg_mag, oriented by RelativeCS7], magnet_8 [N44SH_20deg_mag, oriented by RelativeCS8], magnet_9 [N44SH_20deg_mag, oriented by RelativeCS9] = magnet.duplicate_around_axis(axis=Z, angle=36deg, total=10)
  coordinate_system RelativeCS1 = origin=(0mm, 0mm, 0mm) Euler Angle ZXZ phi=54deg theta=0deg psi=180deg
  coordinate_system RelativeCS2 = origin=(0mm, 0mm, 0mm) Euler Angle ZXZ phi=90deg theta=0deg psi=0deg
  coordinate_system RelativeCS3 = origin=(0mm, 0mm, 0mm) Euler Angle ZXZ phi=126deg theta=0deg psi=180deg
  coordinate_system RelativeCS4 = origin=(0mm, 0mm, 0mm) Euler Angle ZXZ phi=162deg theta=0deg psi=0deg
  coordinate_system RelativeCS5 = origin=(0mm, 0mm, 0mm) Euler Angle ZXZ phi=198deg theta=0deg psi=180deg
  coordinate_system RelativeCS6 = origin=(0mm, 0mm, 0mm) Euler Angle ZXZ phi=234deg theta=0deg psi=0deg
  coordinate_system RelativeCS7 = origin=(0mm, 0mm, 0mm) Euler Angle ZXZ phi=270deg theta=0deg psi=180deg
  coordinate_system RelativeCS8 = origin=(0mm, 0mm, 0mm) Euler Angle ZXZ phi=306deg theta=0deg psi=0deg
  coordinate_system RelativeCS9 = origin=(0mm, 0mm, 0mm) Euler Angle ZXZ phi=342deg theta=0deg psi=180deg
  Ain1 [copper] = user_primitive(RMxprt/LapCoil.dll, DiaGap=Dsi, DiaYoke=Dso, Length=0mm, Skew=0deg, Slots=slot, SlotType=3, Hs0=Hs0, Hs1=Hs1, Hs2=Hs2, Bs0=Bs0, Bs1=Bs1, Bs2=Bs2, Rs=Rs, FilletType=2, Layers=2, CoilPitch=1, EndExt=5mm, SpanExt=25mm, BendAngle=0deg, SegAngle=10deg, LenRegion=200mm, InfoCoil=1)
  Aout1 [copper] = Ain1.separate_bodies()
  Aout2, Bout1, Bin2, Cin1, Cout2, Aout3, Ain4, Bin3, Bout4, Cout3, Cin4 [copper] = Ain1.duplicate_around_axis(axis=Z, angle=30deg, total=12)
  Ain2, Bin1, Bout2, Cout1, Cin2, Ain3, Aout4, Bout3, Bin4, Cin3, Cout4 [copper] = Aout1.duplicate_around_axis(axis=Z, angle=30deg, total=12)
  outerband [vacuum] = circle(normal=Z, centre=(0mm, 0mm, 0mm), radius=outer_band_D/2)
  rotaband [vacuum] = regular_polygon(axis=Z, centre=(0mm, 0mm, 0mm), first_corner=(rota_band_D/2, 0mm, 0mm), sides=360)
motion:
  MotionSetup1: Band Move_Type=Rotate Coordinate_System=Global Axis=Z Is_Positive=true InitPos=ini_angle Angular_Velocity=speed_rpm Objects=rotaband
  Moving1: Moving Objects=[rotor, magnet, magnet_1..magnet_9]
boundaries and excitations:
  VectorPotential1: Vector Potential Edges=outerband.edge(1 of 1) Value=0
  Ain1: Coil Objects=Ain1 Conductor_number=N Winding=Winding_A PolarityType=Negative
  Ain2: Coil Objects=Ain2 Conductor_number=N Winding=Winding_A PolarityType=Negative
  Ain3: Coil Objects=Ain3 Conductor_number=N Winding=Winding_A PolarityType=Negative
  Ain4: Coil Objects=Ain4 Conductor_number=N Winding=Winding_A PolarityType=Negative
  Aout1: Coil Objects=Aout1 Conductor_number=N Winding=Winding_A PolarityType=Positive
  Aout2: Coil Objects=Aout2 Conductor_number=N Winding=Winding_A PolarityType=Positive
  Aout3: Coil Objects=Aout3 Conductor_number=N Winding=Winding_A PolarityType=Positive
  Aout4: Coil Objects=Aout4 Conductor_number=N Winding=Winding_A PolarityType=Positive
  Bin1: Coil Objects=Bin1 Conductor_number=N Winding=Winding_B PolarityType=Negative
  Bin2: Coil Objects=Bin2 Conductor_number=N Winding=Winding_B PolarityType=Negative
  Bin3: Coil Objects=Bin3 Conductor_number=N Winding=Winding_B PolarityType=Negative
  Bin4: Coil Objects=Bin4 Conductor_number=N Winding=Winding_B PolarityType=Negative
  Bout1: Coil Objects=Bout1 Conductor_number=N Winding=Winding_B PolarityType=Positive
  Bout2: Coil Objects=Bout2 Conductor_number=N Winding=Winding_B PolarityType=Positive
  Bout3: Coil Objects=Bout3 Conductor_number=N Winding=Winding_B PolarityType=Positive
  Bout4: Coil Objects=Bout4 Conductor_number=N Winding=Winding_B PolarityType=Positive
  Cin1: Coil Objects=Cin1 Conductor_number=N Winding=Winding_C PolarityType=Negative
  Cin2: Coil Objects=Cin2 Conductor_number=N Winding=Winding_C PolarityType=Negative
  Cin3: Coil Objects=Cin3 Conductor_number=N Winding=Winding_C PolarityType=Negative
  Cin4: Coil Objects=Cin4 Conductor_number=N Winding=Winding_C PolarityType=Negative
  Cout1: Coil Objects=Cout1 Conductor_number=N Winding=Winding_C PolarityType=Positive
  Cout2: Coil Objects=Cout2 Conductor_number=N Winding=Winding_C PolarityType=Positive
  Cout3: Coil Objects=Cout3 Conductor_number=N Winding=Winding_C PolarityType=Positive
  Cout4: Coil Objects=Cout4 Conductor_number=N Winding=Winding_C PolarityType=Positive
  Winding_A: Winding Group Type=Current IsSolid=false Current=I_ph_A ParallelBranchesNum=1
  Winding_B: Winding Group Type=Current IsSolid=false Current=I_ph_B ParallelBranchesNum=1
  Winding_C: Winding Group Type=Current IsSolid=false Current=I_ph_C ParallelBranchesNum=1
  core loss on: stator, rotor
mesh:
  mesh: LengthBased RefineInside Objects=rotaband MaxLength=0.5mm
  initial mesh: MeshMethod=AnsoftTAU
setups:
  setup1: Transient NonlinearSolverResidual=0.0001 StopTime=1/(speed_rpm/60*(pole/2)/1rpm) TimeStep=1/(speed_rpm/60*(pole/2)/1rpm)/50 SweepSetupType=LinearStep StartValue=0s StopValue=10000000s StepSize=5000000s InitialTimeStep=0.002s MinTimeStep=0.001s MaxTimeStep=0.003s TimeStepErrTolerance=0.0001
optimetrics:
  OPT: Parametric Sim._Setups=[setup1]
    sweep Im: 0A
    sweep speed_rpm: 1000rpm
    table edits: add(297A, 1769rpm)
reports:
  Moving1.Torque: Moving1.Torque vs Time on setup1 : Transient [Dso=all Hs0=all Hs1=all Bs0=all Rs=all pole=all rotor_type=all mag_emb=all mag_thick=all mag_width=all rotor_bridge=all rotor_rib=all ini_angle=all speed_rpm=all length=all multiplier=all N=all Im=all lead_ang=all]
  InducedVoltage(Winding_A): InducedVoltage(Winding_A) vs Time on setup1 : Transient [Dso=all Hs0=all Hs1=all Bs0=all Rs=all pole=all rotor_type=all mag_emb=all mag_thick=all mag_width=all rotor_bridge=all rotor_rib=all ini_angle=all speed_rpm=all length=all multiplier=all N=all Im=all lead_ang=all]
  InducedVoltage(Winding_A)-InducedVoltage(Winding_B): InducedVoltage(Winding_A)-InducedVoltage(Winding_B) vs Time on setup1 : Transient [Dso=all Hs0=all Hs1=all Bs0=all Rs=all pole=all rotor_type=all mag_emb=all mag_thick=all mag_width=all rotor_bridge=all rotor_rib=all ini_angle=all speed_rpm=all length=all multiplier=all N=all Im=all lead_ang=all]
  CoreLoss: CoreLoss vs Time on setup1 : Transient [Dso=all Hs0=all Hs1=all Bs0=all Rs=all pole=all rotor_type=all mag_emb=all mag_thick=all mag_width=all rotor_bridge=all rotor_rib=all ini_angle=all speed_rpm=all length=all multiplier=all N=all Im=all lead_ang=all]
  Torque Table 1: Moving1.LoadTorque vs Time on setup1 : Transient [speed_rpm=all Im=all]
